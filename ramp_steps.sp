* Stepped-input (DC sweep) stimulus for AF6859 DSM: replace vinp/vinn/.tran in the ramp netlist.
* 64 steps of 1200 clocks (100.0 us); diff (vip-vin) = 0 .. 0.3 V, common mode 0.75 V.
* Analyse:  python dsm_ramp.py dc <exported table> --step 1200 --skip 200
vinp vip 0 pwl(0.000000e+00 0.750000 9.900000e-05 0.750000 1.000000e-04 0.752381 1.990000e-04 0.752381 2.000000e-04 0.754762 2.990000e-04 0.754762 3.000000e-04 0.757143 3.990000e-04 0.757143 4.000000e-04 0.759524 4.990000e-04 0.759524 5.000000e-04 0.761905 5.990000e-04 0.761905 6.000000e-04 0.764286 6.990000e-04 0.764286 7.000000e-04 0.766667 7.990000e-04 0.766667 8.000000e-04 0.769048 8.990000e-04 0.769048 9.000000e-04 0.771429 9.990000e-04 0.771429 1.000000e-03 0.773810 1.099000e-03 0.773810 1.100000e-03 0.776190 1.199000e-03 0.776190 1.200000e-03 0.778571 1.299000e-03 0.778571 1.300000e-03 0.780952 1.399000e-03 0.780952 1.400000e-03 0.783333 1.499000e-03 0.783333 1.500000e-03 0.785714 1.599000e-03 0.785714 1.600000e-03 0.788095 1.699000e-03 0.788095 1.700000e-03 0.790476 1.799000e-03 0.790476 1.800000e-03 0.792857 1.899000e-03 0.792857 1.900000e-03 0.795238 1.999000e-03 0.795238 2.000000e-03 0.797619 2.099000e-03 0.797619 2.100000e-03 0.800000 2.199000e-03 0.800000 2.200000e-03 0.802381 2.299000e-03 0.802381 2.300000e-03 0.804762 2.399000e-03 0.804762 2.400000e-03 0.807143 2.499000e-03 0.807143 2.500000e-03 0.809524 2.599000e-03 0.809524 2.600000e-03 0.811905 2.699000e-03 0.811905 2.700000e-03 0.814286 2.799000e-03 0.814286 2.800000e-03 0.816667 2.899000e-03 0.816667 2.900000e-03 0.819048 2.999000e-03 0.819048 3.000000e-03 0.821429 3.099000e-03 0.821429 3.100000e-03 0.823810 3.199000e-03 0.823810 3.200000e-03 0.826190 3.299000e-03 0.826190 3.300000e-03 0.828571 3.399000e-03 0.828571 3.400000e-03 0.830952 3.499000e-03 0.830952 3.500000e-03 0.833333 3.599000e-03 0.833333 3.600000e-03 0.835714 3.699000e-03 0.835714 3.700000e-03 0.838095 3.799000e-03 0.838095 3.800000e-03 0.840476 3.899000e-03 0.840476 3.900000e-03 0.842857 3.999000e-03 0.842857 4.000000e-03 0.845238 4.099000e-03 0.845238 4.100000e-03 0.847619 4.199000e-03 0.847619 4.200000e-03 0.850000 4.299000e-03 0.850000 4.300000e-03 0.852381 4.399000e-03 0.852381 4.400000e-03 0.854762 4.499000e-03 0.854762 4.500000e-03 0.857143 4.599000e-03 0.857143 4.600000e-03 0.859524 4.699000e-03 0.859524 4.700000e-03 0.861905 4.799000e-03 0.861905 4.800000e-03 0.864286 4.899000e-03 0.864286 4.900000e-03 0.866667 4.999000e-03 0.866667 5.000000e-03 0.869048 5.099000e-03 0.869048 5.100000e-03 0.871429 5.199000e-03 0.871429 5.200000e-03 0.873810 5.299000e-03 0.873810 5.300000e-03 0.876190 5.399000e-03 0.876190 5.400000e-03 0.878571 5.499000e-03 0.878571 5.500000e-03 0.880952 5.599000e-03 0.880952 5.600000e-03 0.883333 5.699000e-03 0.883333 5.700000e-03 0.885714 5.799000e-03 0.885714 5.800000e-03 0.888095 5.899000e-03 0.888095 5.900000e-03 0.890476 5.999000e-03 0.890476 6.000000e-03 0.892857 6.099000e-03 0.892857 6.100000e-03 0.895238 6.199000e-03 0.895238 6.200000e-03 0.897619 6.299000e-03 0.897619 6.300000e-03 0.900000 6.399000e-03 0.900000)
vinn vin 0 pwl(0.000000e+00 0.750000 9.900000e-05 0.750000 1.000000e-04 0.747619 1.990000e-04 0.747619 2.000000e-04 0.745238 2.990000e-04 0.745238 3.000000e-04 0.742857 3.990000e-04 0.742857 4.000000e-04 0.740476 4.990000e-04 0.740476 5.000000e-04 0.738095 5.990000e-04 0.738095 6.000000e-04 0.735714 6.990000e-04 0.735714 7.000000e-04 0.733333 7.990000e-04 0.733333 8.000000e-04 0.730952 8.990000e-04 0.730952 9.000000e-04 0.728571 9.990000e-04 0.728571 1.000000e-03 0.726190 1.099000e-03 0.726190 1.100000e-03 0.723810 1.199000e-03 0.723810 1.200000e-03 0.721429 1.299000e-03 0.721429 1.300000e-03 0.719048 1.399000e-03 0.719048 1.400000e-03 0.716667 1.499000e-03 0.716667 1.500000e-03 0.714286 1.599000e-03 0.714286 1.600000e-03 0.711905 1.699000e-03 0.711905 1.700000e-03 0.709524 1.799000e-03 0.709524 1.800000e-03 0.707143 1.899000e-03 0.707143 1.900000e-03 0.704762 1.999000e-03 0.704762 2.000000e-03 0.702381 2.099000e-03 0.702381 2.100000e-03 0.700000 2.199000e-03 0.700000 2.200000e-03 0.697619 2.299000e-03 0.697619 2.300000e-03 0.695238 2.399000e-03 0.695238 2.400000e-03 0.692857 2.499000e-03 0.692857 2.500000e-03 0.690476 2.599000e-03 0.690476 2.600000e-03 0.688095 2.699000e-03 0.688095 2.700000e-03 0.685714 2.799000e-03 0.685714 2.800000e-03 0.683333 2.899000e-03 0.683333 2.900000e-03 0.680952 2.999000e-03 0.680952 3.000000e-03 0.678571 3.099000e-03 0.678571 3.100000e-03 0.676190 3.199000e-03 0.676190 3.200000e-03 0.673810 3.299000e-03 0.673810 3.300000e-03 0.671429 3.399000e-03 0.671429 3.400000e-03 0.669048 3.499000e-03 0.669048 3.500000e-03 0.666667 3.599000e-03 0.666667 3.600000e-03 0.664286 3.699000e-03 0.664286 3.700000e-03 0.661905 3.799000e-03 0.661905 3.800000e-03 0.659524 3.899000e-03 0.659524 3.900000e-03 0.657143 3.999000e-03 0.657143 4.000000e-03 0.654762 4.099000e-03 0.654762 4.100000e-03 0.652381 4.199000e-03 0.652381 4.200000e-03 0.650000 4.299000e-03 0.650000 4.300000e-03 0.647619 4.399000e-03 0.647619 4.400000e-03 0.645238 4.499000e-03 0.645238 4.500000e-03 0.642857 4.599000e-03 0.642857 4.600000e-03 0.640476 4.699000e-03 0.640476 4.700000e-03 0.638095 4.799000e-03 0.638095 4.800000e-03 0.635714 4.899000e-03 0.635714 4.900000e-03 0.633333 4.999000e-03 0.633333 5.000000e-03 0.630952 5.099000e-03 0.630952 5.100000e-03 0.628571 5.199000e-03 0.628571 5.200000e-03 0.626190 5.299000e-03 0.626190 5.300000e-03 0.623810 5.399000e-03 0.623810 5.400000e-03 0.621429 5.499000e-03 0.621429 5.500000e-03 0.619048 5.599000e-03 0.619048 5.600000e-03 0.616667 5.699000e-03 0.616667 5.700000e-03 0.614286 5.799000e-03 0.614286 5.800000e-03 0.611905 5.899000e-03 0.611905 5.900000e-03 0.609524 5.999000e-03 0.609524 6.000000e-03 0.607143 6.099000e-03 0.607143 6.100000e-03 0.604762 6.199000e-03 0.604762 6.200000e-03 0.602381 6.299000e-03 0.602381 6.300000e-03 0.600000 6.399000e-03 0.600000)
.tran 'tck' 6.400000e-03 start='ts_off'
* Export columns: TIME v(vin) v(vip) v(qout)  (one row per clock). Run several noise seeds and
* average the results, or raise 1200 (longer steps -> less noise per point), to lower the INL.
